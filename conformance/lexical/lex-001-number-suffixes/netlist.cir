LEX-001 number suffixes and unit letters
* Each source value is read back as a node voltage across 1k to ground.
V1 a 0 1A
V2 b 0 1F
V3 c 0 1G
V4 d 0 1T
V5 e 0 5V
V6 f 0 1U
V7 g 0 1MEGOHM
V8 h 0 1Mi
V9 i 0 1mil
V10 j 0 10Volts
V11 k 0 1Hz
V12 l 0 2MA
V13 m 0 DC=3
V14 n 0 3.5E-1V
Vx x 0 0
R1 a 0 1k
R2 b 0 1k
R3 c 0 1k
R4 d 0 1k
R5 e 0 1k
R6 f 0 1k
R7 g 0 1k
R8 h 0 1k
R9 i 0 1k
R10 j 0 1k
R11 k 0 1k
R12 l 0 1k
R13 m 0 1k
R14 n 0 1k
.dc Vx 0 0 1
.print dc v(a) v(b) v(c) v(d) v(e) v(f) v(g)
.print dc v(h) v(i) v(j) v(k) v(l) v(m) v(n)
.end
